** Profile: "SCHEMATIC1-4_78"  [ D:\On Editing\Sophomore\VE215,Intro to Circuits\4_78-PSpiceFiles\SCHEMATIC1\4_78.sim ]

** Creating circuit file "4_78.cir"
** WARNING: THIS AUTOMATICALLY GENERATED FILE MAY BE OVERWRITTEN BY SUBSEQUENT SIMULATIONS

*Libraries:
* Profile Libraries :
* Local Libraries :
* From [PSPICE NETLIST] section of E:\Cadence\SPB_Data\cdssetup\OrCAD_PSpice\17.2.0\PSpice.ini file:
.lib "nom.lib"

*Analysis directives:
.DC LIN I_I1 0 0.1 0.0001
.OPTIONS ADVCONV
.PROBE64 V(alias(*)) I(alias(*)) W(alias(*)) D(alias(*)) NOISE(alias(*))
.INC "..\SCHEMATIC1.net"

.END
