** Profile: "SCHEMATIC1-14_84"  [ D:\On Editing\Sophomore\VE215,Intro to Circuits\14_84-PSpiceFiles\SCHEMATIC1\14_84.sim ]

** Creating circuit file "14_84.cir"
** WARNING: THIS AUTOMATICALLY GENERATED FILE MAY BE OVERWRITTEN BY SUBSEQUENT SIMULATIONS

*Libraries:
* Profile Libraries :
* Local Libraries :
* From [PSPICE NETLIST] section of E:\Cadence\SPB_Data\cdssetup\OrCAD_PSpice\17.2.0\PSpice.ini file:
.lib "nom.lib"

*Analysis directives:
.AC DEC 50 1 1.00k
.OPTIONS ADVCONV
.PROBE64 V(alias(*)) I(alias(*)) W(alias(*)) D(alias(*)) NOISE(alias(*))
.INC "..\SCHEMATIC1.net"

.END
